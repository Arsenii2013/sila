
`include "device_info_axi_core.rdl"
`include "link_csr_axi_core.rdl"
`include "timestamper_axi_core.rdl"
`include "ev_map_axi_core.rdl"
`include "signal_gen_ctrl_axi_core.rdl"
`include "sfp_control_axi_core.rdl"

`define GP0_ADDR_W       21
`define GP0_DATA_W       32

`define MMR_BLOCK_ADDR_W 16 // 0x10000 per device
`define MMR_BLOCK_DATA_W `GP0_DATA_W
`define MMR_BLOCK_SIZE   2**`MMR_BLOCK_ADDR_W

`define MMR_DEV_ADDR_W   (`GP0_ADDR_W - `MMR_BLOCK_ADDR_W)
`define MMR_DEV_CNT      2**`MMR_DEV_ADDR_W
`define MAX_DEVICE       (`MMR_DEV_CNT - 1)

`define DEBUG_DEVICE     (`MMR_DEV_CNT / 2)

addrmap EVR_reg_map {
    name = "Блок приемника событий";
    desc = "
        Блок приемника событий, слейв сети.
    ";
    default accesswidth = `MMR_BLOCK_DATA_W;
    default alignment   = 0x4;
    alignment   = `MMR_BLOCK_SIZE;
    
    enum gp0_params{
        GP0_ADDR_W       = `GP0_ADDR_W;
        GP0_DATA_W       = `GP0_DATA_W;
    };
    enum mmr_params{
        MMR_BLOCK_ADDR_W = `MMR_BLOCK_ADDR_W;
        MMR_BLOCK_DATA_W = `MMR_BLOCK_DATA_W;
    };
    enum mmr_dev_params{
        MMR_DEV_CNT      = `MMR_DEV_CNT;
    };
    enum signal_gen_params{
        SIGNAL_GEN_N      = `SIGNAL_GEN_N;
    };
    enum ev_comp_params{
        EV_COMP_N      = `EV_COMP_N;
    };

    enum device_numbers{
        DEVICE_INFO = 0;
        EVR;
        TIMESTAMPER;
        EV_MAP;
        SIG_GEN_CTRL;
        SFP_CONTROL = `DEBUG_DEVICE;
        EVENT_COMPARATOR;
        MAX_DEVICE  = `MAX_DEVICE;
    };

    device_info_axi_core     device_info     @ device_numbers::DEVICE_INFO  * `MMR_BLOCK_SIZE;
    link_csr_axi_core        evr_ctrl        @ device_numbers::EVR          * `MMR_BLOCK_SIZE;
    timestamper_axi_core     timestamper     @ device_numbers::TIMESTAMPER  * `MMR_BLOCK_SIZE;
    ev_map_axi_core          ev_map          @ device_numbers::EV_MAP       * `MMR_BLOCK_SIZE;
    signal_gen_ctrl_axi_core signal_gen_ctrl @ device_numbers::SIG_GEN_CTRL * `MMR_BLOCK_SIZE;
    sfp_control_axi_core     sfp_control     @ device_numbers::SFP_CONTROL  * `MMR_BLOCK_SIZE;


    regfile {
        name = "Фейковый блок регистров";
        desc = "
            !!! Эти регистры не существуют, и добавлены для того,                 !!!
            !!! чтобы генерировались enum-ы с параметрами для передачи в verilog. !!!
            !!! При подготовке карты регистров убрать.                            !!!
        ";
        reg {
            field {encode = device_numbers;} mmr_device_numbers[32];
        } mmr_device_numbers;
        reg {
            field {encode = gp0_params;} gp0_axi_params[32];
        } gp0_axi_params;
        reg {
            field {encode = mmr_params;} mmr_params[32];
        } mmr_params;
        reg {
            field {encode = mmr_dev_params;} mmr_dev_params[32];
        } mmr_dev_params;
        reg {
            field {encode = signal_gen_params;} signal_gen_params[32];
        } signal_gen_params;
        reg {
            field {encode = ev_comp_params;} ev_comp_params[32];
        } ev_comp_params;
    } fake_regfile @ device_numbers::MAX_DEVICE * `MMR_BLOCK_SIZE;
};