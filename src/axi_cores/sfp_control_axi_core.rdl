addrmap sfp_control_axi_core{
    name = "Блок отладочных регистров оптической сети";
    reg {
        name = "SFP_LOSS";
        field {sw=rw; hw=r;} sfp_loss[4] = 1;
    } sfp_loss;
};