addrmap ev_seq_ctrl_axi_core{
    name = "Модуль управления генераторами последовательностей";
    desc = "
        Модуль генераторами последовательностей управляет генераторами. Управление генераторами 
        состоит из запуска и остановки генераторов исходя из внешних триггеров, режима работы,
        и значения управляющего регистра. Для каждого генератора выделен свой блок регистров seq_reg, 
        а также для удобства управления некоторые поля сведены в общие регистры управления. 
        Каждому генератору соответствует своя управляющая машина состояний с тремя состояниями:
        DISABLED, ENABLED, RUNNING. В состоянии DISABLED машина не реагирует на внешние триггеры и 
        не запускает генератор. В состоянии ENABLED машина ожидает триггер, и по нему запускает генерацию
        и переходит в состояние RUNNING. Состояние RUNNING означает что идет генерация последовательности. 
        Переход из состояния DISABLED в ENABLED разрешает флаг enabled. Состояние RUNNING показано флагом
        running. 
        Машина состояний может работать в одном из трех режимов работы: SINGLE - однократный режим работы,
        CYCLE - многократный режим работы, RECYCLE - режим автоматического перезапуска. В однократном 
        режиме работы машина ждет триггера, генерирует последовательность, сбрасывает enable и переходит
        в состояние DISABLED. В многократном режиме работы машина ждет триггера, генерирует последовательность,
        оставляет enable, переходит в состояние ENABLED и снова ждет триггер, и т.д. В режиме RECYCLE 
        машина ждет триггер, генерирует последовательность, остается в состоянии RUNNING и снова генерирует 
        последовательность, и т. д. 
        В любом режиме работы машина по окончании генерации проверяет значение enable, и если enable = 0, то 
        переходит в состояние DISABLED. Для безусловного (не дожидаясь конца генерации) перехода в состояние 
        DISABLE предназначен бит reset. 
        Помимо управления генераторами модуль управления позволяет сгенерировать одиночное программное событие 
        без настройки генераторов, в регистре PROG_EV. Модуль управления приоритезирует события от разных источников: 
        при одновременной генерации событий из разных источников значение события определяется в следующем
        порядке: программное событие, генераторы в порядке увеличения номера. Событие с низким приоритетом 
        не генерируется и теряется.
    ";

    `define EV_SEQ_N 2
    <% $EV_SEQ_N_PERL = 2; %> // должно быть равно дефайну!!!

    enum trig_src_t {
        PROG    = 32'h0;
    };
    enum sq_mode_t {
        SINGLE  = 32'h0;
        CYCLE   = 32'h1;
        RECYCLE = 32'h2;
    };


    reg {
        name = "SR";
        desc = "
            Регистр статуса модуля.
        ";
        field {sw=r; hw=w;
        desc = "
            Флаг, показывающий состояние RUNNING стоответствующего секвенсера.
        ";
        }   seq_running[`EV_SEQ_N] = 0;
    } sr;

    reg {
        name = "CR";
        desc = "
            Регистр управления модулем.
        ";
        field {sw=rw; hw=rw; swmod;
        desc = "
            Включение генератора.
        ";
        } seq_enable[`EV_SEQ_N] = 0;
        field {sw=rw; hw=rw; swmod;
        desc = "
            Сброс генератора.
        ";
        }  seq_reset[`EV_SEQ_N] = 0;
    } cr;

    reg {
        name = "CR_S";
        desc = "
            Регистр управления модулем.
            При чтении возвращает 0.
            При записи, в регистр cr устанавливается значение cr | cr_s (ИЛИ), то есть выставляются в 1 все биты, выставленные в 1 регистре cr_s.
        ";
        field {sw=w; hw=rw; swmod;
        desc = "
            Включение генератора.
        ";
        }  seq_enable[`EV_SEQ_N] = 0;
        field {sw=w; hw=rw; swmod;
        desc = "
            Сброс генератора.
        ";
        }   seq_reset[`EV_SEQ_N] = 0;
    } cr_s;

    reg {
        name = "CR_C";
        desc = "
            Регистр управления модулем.
            При чтении возвращает 0.
            При записи, в регистр cr устанавливается значение cr & ~cr_c, то есть выставляются в 0 все биты, выставленные в 1 регистре cr_s.
        ";
        field {sw=w; hw=rw; swmod;
        desc = "
            Включение генератора.
        ";
        }  seq_enable[`EV_SEQ_N] = 0;
        field {sw=w; hw=rw; swmod;
        desc = "
            Сброс генератора.
        ";
        }   seq_reset[`EV_SEQ_N] = 0;
    } cr_c;

    reg {
        name = "PROG_EV";
        desc = "
            Регистр генерации программного события.
        ";
        field {sw=rw; hw=r;
        desc = "
            Событие которое нужно сгенерировать.
        ";
        }  ev[24]            = 0;
        field {sw=rw; hw=rw;
        desc = "
            Сгенерировать событие. Для генерации записать \"1\". После генерации сбрасывается.
        ";
        } send              = 0;
    } prog_ev;

    regfile {
        reg {
            name = "SQ_SR";
            desc = "
                Регистр статуса секвенсера.
            ";
            field {sw=r; hw=w;
            desc = "
                Флаг, показывающий состояние RUNNING.
            ";
            }   running     = 0;
        } sq_sr;
        reg {
            name = "SQ_CR";
            desc = "
                Регистр управления модулем.
            ";
            field {sw=rw; hw=rw; swmod;
            desc = "
                Включение генератора.
            ";
            } enable     = 0;
            field {sw=rw; hw=rw; swmod;
            desc = "
                Сброс генератора.
            ";
            } reset      = 0;
            field {sw=rw; hw=rw;
            desc = "
                Программный триггер.
            ";
            } sw_trig           = 0;
        } sq_cr;
        reg {
            name = "SQ_CR_S";
            desc = "
                Регистр управления модулем.
                При чтении возвращает 0.
                При записи, в регистр cr устанавливается значение cr | cr_s (ИЛИ), то есть выставляются в 1 все биты, выставленные в 1 регистре cr_s.
            ";
            field {sw=w; hw=rw; swmod;
            desc = "
                Включение генератора.
            ";
            }  enable     = 0;
            field {sw=w; hw=rw; swmod;
            desc = "
                Сброс генератора.
            ";
            }  reset      = 0;
            field {sw=w; hw=rw;
            desc = "
                Программный триггер.
            ";
            }  sw_trig           = 0;
        } sq_cr_s;
        reg {
            name = "SQ_CR_C";
            desc = "
                Регистр управления модулем.
                При чтении возвращает 0.
                При записи, в регистр cr устанавливается значение cr & ~cr_c, то есть выставляются в 0 все биты, выставленные в 1 регистре cr_s.
            ";
            field {sw=w; hw=rw; swmod;
            desc = "
                Включение генератора.
            ";
            }  enable     = 0;
            field {sw=w; hw=rw; swmod;
            desc = "
                Сброс генератора.
            ";
            }  reset      = 0;
            field {sw=w; hw=rw;
            desc = "
                Программный триггер.
            ";
            }  sw_trig           = 0;
        } sq_cr_c;

        reg {
            name = "TRIG";
            desc = "
                Источник запуска секвенсера.
                PROG = 0 - Программный запуск.
            ";
            field {sw=rw; hw=r; encode=trig_src_t;} src[2] = trig_src_t::PROG;
        } trig;

        reg {
            name = "MODE";
            desc = "
                Режим работы секвенсера.
                SINGLE = 0 - однократный.
                CYCLE = 1 - многократный.
                RECYCLE = 2 - режим циклического перезапуска.
            ";
            field {sw=rw; hw=r; encode=sq_mode_t;} mode[2] = sq_mode_t::SINGLE;
        } mode;
    } seq_regs [`EV_SEQ_N];
};