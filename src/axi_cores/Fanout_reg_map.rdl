
`include "device_info_axi_core.rdl"
`include "link_csr_axi_core.rdl"
`include "timestamper_axi_core.rdl"
`include "sfp_control_axi_core.rdl"
`include "rdl_axi_params.rdl"

addrmap Fanout_reg_map {
    name = "Блок разветвителя сети";
    desc = "
        Прошивка МСГ в роли разветвителя сети состоит из следующих функциональных модулей:
    ";
    default accesswidth = `MMR_BLOCK_DATA_W;
    default alignment   = 0x4;
    alignment   = `MMR_BLOCK_SIZE;

    enum device_numbers{
        DEVICE_INFO = 0;
        FANOUT;
        TIMESTAMPER;
        SFP_CONTROL = `DEBUG_DEVICE;
        MAX_DEVICE  = `MAX_DEVICE;
    };

    device_info_axi_core device_info  @ device_numbers::DEVICE_INFO    * `MMR_BLOCK_SIZE;
    link_csr_axi_core    fanout_ctrl  @ device_numbers::FANOUT         * `MMR_BLOCK_SIZE;
    timestamper_axi_core timestamper  @ device_numbers::TIMESTAMPER    * `MMR_BLOCK_SIZE;
    sfp_control_axi_core sfp_control  @ device_numbers::SFP_CONTROL    * `MMR_BLOCK_SIZE;


    regfile {
        name = "Фейковый блок регистров";
        desc = "
            !!! Эти регистры не существуют, и добавлены для того,                 !!!
            !!! чтобы генерировались enum-ы с параметрами для передачи в verilog. !!!
            !!! При подготовке карты регистров убрать.                            !!!
        ";
        reg {
            field {encode = device_numbers;} mmr_device_numbers[32];
        } mmr_device_numbers;
    } fake_regfile @ device_numbers::MAX_DEVICE * `MMR_BLOCK_SIZE;
};