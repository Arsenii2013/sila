
`include "device_info_axi_core.rdl"
`include "link_csr_axi_core.rdl"
`include "timestamper_axi_core.rdl"
`include "ev_seq_ctrl_axi_core.rdl"
`include "ev_seq_axi_core.rdl"
`include "i2c_mux_axi_core.rdl"
`include "rdl_axi_params.rdl"

addrmap HSSM_reg_map {
    name = "Блок генерации событий";
    desc = "
        Прошивка МСГ в роли головного устройства состоит из следующих функциональных модулей:
    ";
    default accesswidth = `MMR_BLOCK_DATA_W;
    default alignment   = 0x4;
    alignment   = `MMR_BLOCK_SIZE;

    enum ev_seq_params{
        EV_SEQ_N         = `EV_SEQ_N;
    };

    enum device_numbers{
        DEVICE_INFO = 0;
        HSSM;
        TIMESTAMPER;
        EV_SEQ_CTRL;
        <% for( $i = 0; $i < $EV_SEQ_N_PERL; $i += 1 ) { %>
        EV_SEQ_<%=$i%>;
        <% } %>
        I2C_MUX = `DEBUG_DEVICE;
        EVENT_COMPARATOR;
        MAX_DEVICE  = `MAX_DEVICE;
    };

    device_info_axi_core device_info  @ device_numbers::DEVICE_INFO    * `MMR_BLOCK_SIZE;
    link_csr_axi_core    evg_ctrl     @ device_numbers::HSSM            * `MMR_BLOCK_SIZE;
    timestamper_axi_core timestamper  @ device_numbers::TIMESTAMPER    * `MMR_BLOCK_SIZE;
    ev_seq_ctrl_axi_core ev_seq_ctrl  @ device_numbers::EV_SEQ_CTRL    * `MMR_BLOCK_SIZE;
    <% for( $i = 0; $i < $EV_SEQ_N_PERL; $i += 1 ) { %>
    ev_seq_axi_core ev_seq_<%=$i%>    @ device_numbers::EV_SEQ_<%=$i%> * `MMR_BLOCK_SIZE;
    <% } %>
    i2c_mux_axi_core     i2c_mux      @ device_numbers::I2C_MUX        * `MMR_BLOCK_SIZE;


    regfile {
        name = "Фейковый блок регистров";
        desc = "
            !!! Эти регистры не существуют, и добавлены для того,                 !!!
            !!! чтобы генерировались enum-ы с параметрами для передачи в verilog. !!!
            !!! При подготовке карты регистров убрать.                            !!!
        ";
        reg {
            field {encode = device_numbers;} mmr_device_numbers[32];
        } mmr_device_numbers;
        reg {
            field {encode = ev_seq_params;} ev_seq_params[32];
        } ev_seq_params;
    } fake_regfile @ device_numbers::MAX_DEVICE * `MMR_BLOCK_SIZE;
};