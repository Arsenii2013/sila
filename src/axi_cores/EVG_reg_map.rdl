
`include "device_info_axi_core.rdl"
`include "evg_axi_core.rdl"

`define GP0_ADDR_W       21
`define GP0_DATA_W       32

`define MMR_BLOCK_ADDR_W 16 // 0x10000 per device
`define MMR_BLOCK_DATA_W `GP0_DATA_W
`define MMR_BLOCK_SIZE   2**`MMR_BLOCK_ADDR_W

`define MMR_DEV_ADDR_W   (`GP0_ADDR_W - `MMR_BLOCK_ADDR_W)
`define MMR_DEV_CNT      2**`MMR_DEV_ADDR_W
`define MAX_DEVICE       (`MMR_DEV_CNT - 1)

`define DEBUG_DEVICE     (`MMR_DEV_CNT / 2)

addrmap EVG_reg_map {
    name = "Блок генерации событий";
    desc = "
        Блок генерирующий события, мастер сети.
    ";
    default accesswidth = `MMR_BLOCK_DATA_W;
    default alignment   = 0x4;
    alignment   = `MMR_BLOCK_SIZE;
    
    enum gp0_params{
        GP0_ADDR_W       = `GP0_ADDR_W;
        GP0_DATA_W       = `GP0_DATA_W;
    };
    enum mmr_params{
        MMR_BLOCK_ADDR_W = `MMR_BLOCK_ADDR_W;
        MMR_BLOCK_DATA_W = `MMR_BLOCK_DATA_W;
    };
    enum mmr_dev_params{
        MMR_DEV_CNT      = `MMR_DEV_CNT;
    };

    enum device_numbers{
        DEVICE_INFO = 0;
        TIMESTAMPER;
        SFP_CONTROL = `DEBUG_DEVICE;
        EVG1;
        EVG2;
        EVENT_COMPARATOR;
        MAX_DEVICE  = `MAX_DEVICE;
    };

    device_info_axi_core device_info_axi_core  @ device_numbers::DEVICE_INFO  * `MMR_BLOCK_SIZE;
    evg_axi_core evg_axi_core1                 @ device_numbers::EVG1         * `MMR_BLOCK_SIZE;
    evg_axi_core evg_axi_core2                 @ device_numbers::EVG2         * `MMR_BLOCK_SIZE;


    regfile {
        name = "Фейковый блок регистров";
        desc = "
            !!! Эти регистры не существуют, и добавлены для того,                 !!!
            !!! чтобы генерировались enum-ы с параметрами для передачи в verilog. !!!
            !!! При подготовке карты регистров убрать.                            !!!
        ";
        reg {
            field {encode = device_numbers;} mmr_device_numbers[`MMR_DEV_ADDR_W];
        } mmr_device_numbers;
        reg {
            field {encode = gp0_params;} gp0_axi_params[`GP0_DATA_W];
        } gp0_axi_params;
        reg {
            field {encode = mmr_params;} mmr_params[`MMR_BLOCK_DATA_W];
        } mmr_params;
        reg {
            field {encode = mmr_dev_params;} mmr_dev_params[`MMR_DEV_CNT];
        } mmr_dev_params;
    } fake_regfile @ device_numbers::MAX_DEVICE * `MMR_BLOCK_SIZE;
};