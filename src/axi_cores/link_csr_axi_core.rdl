addrmap link_csr_axi_core{
    name = "Модуль оптической сети";
    `define MAX_PORTS 8
    desc = "
        Модули оптической сети предназначен для управления синхронизацией, получения состояния оптического
        линька, компенсации задержки. Для удобства управления у всех устройств модуль оптической сети одинаковый,
        А неактуальные регистры не используются. В МГС в обоих конфигурациях не актуальна компенсация задержки,
        в МОУ - регистры состояния портов больше нуля.
    ";

    enum link_delay_st {
        ZERO      = 4'h0;
        INITIAL   = 4'h1;
        ONE_CYCLE = 4'h3;
        FINE      = 4'h7;
        ERROR     = 4'h8;
    };

    reg {
        name = "SR";
        desc = "
            Регистр статуса модуля.
        ";
        field {sw=r; hw=w; 
        desc = "
            Выровнялся ли оптический трансивер.
        ";
        } link_up = 0;
        field {sw=r; hw=w; encode=link_delay_st;
        desc = "
            Состояние измерителя задержки.
            ZERO = 0 - измерение задержки не началось.
            INITIAL = 1 - измерение задержки началось.
            ONE_CYCLE = 3 - задержка измерена с точностью лучше 1 такта.
            FINE = 7 - достигнута максимальная точность измерения.
            ERROR = 8 - ошибка.
        ";
        } link_delay_st [7:4]  = link_delay_st::ZERO;
        field {sw=r; hw=w; encode=link_delay_st;
        desc = "
            Состояние компенсатора задержки.
            ZERO - компенсация задержки не началась.
            INITIAL - компенсация задержки началась.
            ONE_CYCLE - задержка скомпенсирована с точностью лучше 1 такта.
            FINE - достигнута максимальная точность компенсации.
            ERROR = 8 - ошибка.
        ";
        } delay_comp_st [11:8] = link_delay_st::ZERO;
    } sr;

    reg {
        name = "CR";
        desc = "
            Регистр управления модулем.
        ";
        field {sw=rw; hw=rw;
        desc = "
            Включение компенсации задержки.
        ";
        } dc_ena = 0;
    } cr;

    reg {
        name = "CR_S";
        desc = "
            Регистр управления модулем.
            При чтении возвращает 0.
            При записи, в регистр cr устанавливается значение cr | cr_s (ИЛИ), то есть выставляются в 1 все биты, выставленные в 1 регистре cr_s.
        ";
        field {sw=w; hw=rw;
        desc = "
            Включение компенсации задержки.
        ";
        } dc_ena = 0;
    } cr_s;

    reg {
        name = "CR_C";
        desc = "
            Регистр управления модулем.
            При чтении возвращает 0.
            При записи, в регистр cr устанавливается значение cr & ~cr_c, то есть выставляются в 0 все биты, выставленные в 1 регистре cr_s.
        ";
        field {sw=w; hw=rw;
        desc = "
            Включение компенсации задержки.
        ";
        } dc_ena = 0;
    } cr_c;

    reg {
        name = "PORT_SR";
        desc = "
            Регистр статуса порта.
        ";
        field {sw=r; hw=w; 
        desc = "
            Выровнялся ли оптический трансивер.
        ";
        } link_up = 0;
        field {sw=r; hw=w; encode=link_delay_st;
        desc = "
            Состояние измерителя задержки.
            ZERO - измерение задержки не началось.
            INITIAL - измерение задержки началось.
            ONE_CYCLE - задержка измерена с точностью лучше 1 такта.
            FINE - достигнута максимальная точность измерения.
        ";
        } link_delay_st [7:4]  = link_delay_st::ZERO;
        field {sw=r; hw=w; encode=link_delay_st;
        desc = "
            Состояние компенсатора задержки.
            ZERO - компенсация задержки не началась.
            INITIAL - компенсация задержки началась.
            ONE_CYCLE - задержка скомпенсирована с точностью лучше 1 такта.
            FINE - достигнута максимальная точность компенсации.
        ";
        } delay_comp_st [11:8] = link_delay_st::ZERO;
    } port_sr[`MAX_PORTS];

    reg {
        name = "TOPO_ID";
        desc = "
            Топологический идентификатор блока. 
            Идентификатор составляется по следующем правилам: 
            * обход дерева осуществляется сверху вниз
            * на номер устройства на уровне определяется последними четырмя битами
            * номер устройства на уровне равен номеру порту + 1
            * при передаче топологического идентефикатора нижестоящим устройствам 
            разветвители сдвигают принятый от вышестоящего устройства идентефикатор на 4 бита 
            и добавляют номер устройства
            * топологический идентификатор головного устройства равен нулю
            Например, если МГС-1 - головное устройство, МГС-2 подключен в нулевой порт МГС-1,
            МОУ-1 подключен в первый порт МГС-1, МОУ-2 подключен во второй порт МГС-2, то
            топологические идентификаторы равны: МГС-1 - 0, МГС-2 - 01, МОУ-1 - 02, МОУ-2 - 012.
        ";
        field {sw=r; hw=w;} topo_id[32] = 0;
    } topo_id;

    reg {
        name = "LINK_DELAY";
        desc = "
            Задержка до ближайщего ведущего устройства, измеренная в тактах опорного сигнала.
            Формат с фиксированной точкой UQ16.16.
            У головного устройства равна нулю.
        ";
        field {sw=r; hw=w;} link_delay[32] = 0;
    } link_delay;

    reg {
        name = "UPSTREAM_DELAY";
        desc = "
            Задержка до головного ведущего устройства, измеренная в тактах опорного сигнала.
            Формат с фиксированной точкой UQ16.16.
            У головного устройства равна нулю.
        ";
        field {sw=r; hw=w;} up_delay[32] = 0;
    } up_delay;

    reg {
        name = "SUBTREE_DELAY";
        desc = "
            Максимальная задержка поддерева, измеренная в тактах опорного сигнала.
            Формат с фиксированной точкой UQ16.16.
            Вычисляется как максимум UPSTREAM_DELAY всех устройств лежащих ниже этого узла.
            У оконечного устройства равна UPSTREAM_DELAY.
        ";
        field {sw=r; hw=w;} sub_delay[32] = 0;
    } sub_delay;

    reg {
        name = "TGT_DELAY";
        desc = "
            Целевая задержка, задается в тактах опорного сигнала.
            Формат с фиксированной точкой UQ16.16.
            Задается в головном устройстве, в остальных доступна только для чтения.
            Распрстраняется вниз по дереву.
        ";
        field {sw=rw; hw=rw; swmod;} tgt_delay [32] = 0;
    } tgt_delay;

    reg {
        name = "DELAY_COMP";
        desc = "
            Компенсация задержки, измеряется в тактах опорного сигнала.
            Формат с фиксированной точкой UQ16.16.
            Задержка компенсируется только в оконечных устройствах.
            Для головного устройства и разветвителей равна нулю.
        ";
        field {sw=r; hw=w;} delay_comp [32] = 0;
    } delay_comp;
};