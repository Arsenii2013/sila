`define GP0_ADDR_W       21
`define GP0_DATA_W       32

`define MMR_BLOCK_ADDR_W 16 // 0x10000 per device
`define MMR_BLOCK_DATA_W `GP0_DATA_W
`define MMR_BLOCK_SIZE   2**`MMR_BLOCK_ADDR_W

`define MMR_DEV_ADDR_W   (`GP0_ADDR_W - `MMR_BLOCK_ADDR_W)
`define MMR_DEV_CNT      2**`MMR_DEV_ADDR_W
`define MAX_DEVICE       (`MMR_DEV_CNT - 1)

`define DEBUG_DEVICE     (`MMR_DEV_CNT / 2)


addrmap rdl_axi_params {
    enum gp0_params{
        GP0_ADDR_W       = `GP0_ADDR_W;
        GP0_DATA_W       = `GP0_DATA_W;
    };
    enum mmr_params{
        MMR_BLOCK_ADDR_W = `MMR_BLOCK_ADDR_W;
        MMR_BLOCK_DATA_W = `MMR_BLOCK_DATA_W;
    };
    enum mmr_dev_params{
        MMR_DEV_CNT      = `MMR_DEV_CNT;
    };
    regfile {
        name = "Фейковый блок регистров";
        desc = "
            !!! Эти регистры не существуют, и добавлены для того,                 !!!
            !!! чтобы генерировались enum-ы с параметрами для передачи в verilog. !!!
            !!! При подготовке карты регистров убрать.                            !!!
        ";
        reg {
            field {encode = gp0_params;} gp0_axi_params[32];
        } gp0_axi_params;
        reg {
            field {encode = mmr_params;} mmr_params[32];
        } mmr_params;
        reg {
            field {encode = mmr_dev_params;} mmr_dev_params[32];
        } mmr_dev_params;
    } fake_regfile ;
};