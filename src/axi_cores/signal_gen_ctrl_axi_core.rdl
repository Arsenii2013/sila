addrmap signal_gen_ctrl_axi_core{
    name = "Модуль генераторов синхросигналов";
    desc = "
        Модуль генерации синхросигналов состоит 16 каналов генерации импульсов. Каналы генерации импульсов привязаны к выходам ЛБГС 
        (В будущем планируется таблица маппинга каналов на выходы). Канал генерации в свою очередь состоит из генератора одиночных 
        импульсов и периодического счетчика. Генератор одиночных импульсов это два счетчика и два компаратора: счетчик и компаратор 
        задержки генерации и счетчик и компаратор ширины импульса, и выходной SR-триггер с логикой приоритизации сигналов сброса и 
        установки. От таблицы маппинга каналу приходит четыре сигнала: set, clear, trigger, cnt_reset. set и clear это сигналы прямой 
        установки и сброса выхода. По trigger запускается генератор одиночных импульсов. По trigger начинает счет счетчик задержки. 
        Когда счетчик задержки досчитывает до значения компаратора задержки, компаратор генерирует сигнал установки триггера, останавливает 
        и сбрасывает в ноль счетчик задержки и запускает счетчик ширины импульса. Когда срабатывает компаратор ширины импульса, 
        он генерирует сигнал сброса триггера и останавливает и сбрасывает в ноль счетчик ширины. В генераторе сигналы set, clear, trigger 
        приоретизируются дважды. Сперва приоритезируются set, clear, trigger от таблицы маппинга, следующим образом: если в один такт 
        приходят несколько сигналов, то обрабатывается только наиболее приоритетный. clear приоритетнее set, set приоритетнее trigger. 
        То есть, если пришел сигнал прямой установки/сброса от таблицы маппинга, то генерация импульса не запускается. Второй раз запросы 
        приоретизируются на входах триггера. Сигналы clear/set от таблицы маппинга приоритетнее сигналов от генератора одиночных импульсов, 
        и clear приоритетнее set. 

        Для периодического режима работы в канале есть периодический счетчик и компаратор. Когда счетчик досчитывает до значения компаратора,
        он генерирует trigger для генератора одиночных импульсов, сбрасывается в ноль и продолжает считать. Для привязки генерации trigger к
        событиям используется сигнал принудительного сброса cnt_reset от таблицы маппинга.

        Режим работы (периодический или однократный) выбирается значением trig_src. Для единообразия задержки генерации в периодическом 
        режим и однократном режиме в тракт trigger от таблицы маппинга добавлена задержка равная задержке от cnt_reset до начала счета 
        периодического счетчика.

        Источником выхода канала может быть: генератор сигналов, постоянный лог. 0, постоянная лог. 1. Значения лог. 0 и лог. 1 определяется
        полярностью выхода. 
    ";

    `define SIGNAL_GEN_N 16

    enum trig_src_t {
        EVENT = 0;
        PERIOD;
    };
    enum output_src_t {
        FORCE_CLEAR = 0;
        FORCE_SET;
        GENERATOR;
    };

    addressing = regalign;
    reg {
        name = "SR";
        desc = "
            Регистр статуса модуля.
        ";
        field {sw=r; hw=w;
        desc = "
            Значение на выходе соответствующего канала.
        ";
        }   gen_output[`SIGNAL_GEN_N] = 0;
    } sr;

    reg {
        name = "CR";
        desc = "
            Регистр управления модулем, в настоящее время не реализован.
        ";
        field {sw=rw; hw=rw;} reserved[32] = 0;
    } cr;

    reg {
        name = "CR_S";
        desc = "
            Регистр управления модулем, в настоящее время не реализован.
            При чтении возвращает 0.
            При записи, в регистр cr устанавливается значение cr | cr_s (ИЛИ), то есть выставляются в 1 все биты, выставленные в 1 регистре cr_s.
        ";
        field {sw=rw; hw=rw;} reserved[32] = 0;
    } cr_s;

    reg {
        name = "CR_C";
        desc = "
            Регистр управления модулем, в настоящее время не реализован.
            При чтении возвращает 0.
            При записи, в регистр cr устанавливается значение cr & ~cr_c, то есть выставляются в 0 все биты, выставленные в 1 регистре cr_s.
        ";
        field {sw=rw; hw=rw;} reserved[32] = 0;
    } cr_c;

    regfile {
        name = "GEN_REGS";
        desc = "
            Регистры канала генерации.
        ";
        reg {
            name = "GEN_SR";
            desc = "
                Регистр состояния канала генерации.
            ";
            field {sw=r; hw=w;}   output     = 0;
        } gen_sr;

        reg {
            name = "GEN_CR";
            desc = "
                Регистр управления каналом генерации сигналов.
            ";
            field {sw=rw; hw=rw;
            desc = "
                Разрешение set от таблицы маппинга.
            ";
            } set_ena       = 0;
            field {sw=rw; hw=rw;
            desc = "
                Разрешение clear от таблицы маппинга.
            ";
            } clear_ena     = 0;
            field {sw=rw; hw=rw;
            desc = "
                Разрешение trigger от таблицы маппинга.
            ";
            } trigger_ena   = 0;
            field {sw=rw; hw=rw;
            desc = "
                Разрешение cnt_reset от таблицы маппинга.
            ";
            } cnt_reset_ena = 0;
            field {sw=rw; hw=rw;
            desc = "
                Полярность выхода.
            ";
            } polarity      = 0;
            field {sw=rw; hw=rw; encode=output_src_t;
            desc = "
                Источник выхода.
                FORCE_CLEAR = 0 - на выход подается значение логического нуля. При положительной полярности - \"0\", при ортицательной - \"1\".
                FORCE_SET = 1 - на выход подается значение логической единицы. При положительной полярности - \"1\", при ортицательной - \"0\".
                GENERATOR = 2 - на выход подается значение выхода генератора.
            ";
            } out_src[2] = output_src_t::FORCE_CLEAR;
            field {sw=rw; hw=rw; encode=trig_src_t;
            desc = "
                Источник триггера генератора одиночных импульсов.
                EVENT = 0 - trigger от таблицы маппинга.
                PERIOD = 1 - переодический счетчик.
            ";
            } trig_src[1]  = trig_src_t::EVENT;
        } gen_cr;

        reg {
            name = "GEN_CR_S";
            desc = "
                Регистр управления каналом генерации сигналов.
                При чтении возвращает 0.
                При записи, в регистр cr устанавливается значение cr | cr_s (ИЛИ), то есть выставляются в 1 все биты, выставленные в 1 регистре cr_s.
            ";
            field {sw=w; hw=rw;
            desc = "
                Разрешение set от таблицы маппинга.
            ";
            } set_ena       = 0;
            field {sw=w; hw=rw;
            desc = "
                Разрешение clear от таблицы маппинга.
            ";
            } clear_ena     = 0;
            field {sw=w; hw=rw;
            desc = "
                Разрешение trigger от таблицы маппинга.
            ";
            } trigger_ena   = 0;
            field {sw=w; hw=rw;
            desc = "
                Разрешение cnt_reset от таблицы маппинга.
            ";
            } cnt_reset_ena = 0;
            field {sw=w; hw=rw;
            desc = "
                Полярность выхода.
            ";
            } polarity      = 0;
            field {sw=w; hw=rw; encode=output_src_t;
            desc = "
                Источник выхода.
                FORCE_CLEAR = 0 - на выход подается значение логического нуля. При положительной полярности - \"0\", при ортицательной - \"1\".
                FORCE_SET = 1 - на выход подается значение логической единицы. При положительной полярности - \"1\", при ортицательной - \"0\".
                GENERATOR = 2 - на выход подается значение выхода генератора.
            ";
            } out_src[2] = output_src_t::FORCE_CLEAR;
            field {sw=w; hw=rw; encode=trig_src_t;
            desc = "
                Источник триггера генератора одиночных импульсов.
                EVENT = 0 - trigger от таблицы маппинга.
                PERIOD = 1 - переодический счетчик.
            ";
            } trig_src[1]  = trig_src_t::EVENT;
        } gen_cr_s;

        reg {
            name = "GEN_CR_C";
            desc = "
                Регистр управления каналом генерации сигналов.
                При чтении возвращает 0.
                При записи, в регистр cr устанавливается значение cr & ~cr_c, то есть выставляются в 0 все биты, выставленные в 1 регистре cr_s.
            ";
            field {sw=w; hw=rw;
            desc = "
                Разрешение set от таблицы маппинга.
            ";
            } set_ena       = 0;
            field {sw=w; hw=rw;
            desc = "
                Разрешение clear от таблицы маппинга.
            ";
            } clear_ena     = 0;
            field {sw=w; hw=rw;
            desc = "
                Разрешение trigger от таблицы маппинга.
            ";
            } trigger_ena   = 0;
            field {sw=w; hw=rw;
            desc = "
                Разрешение cnt_reset от таблицы маппинга.
            ";
            } cnt_reset_ena = 0;
            field {sw=w; hw=rw;
            desc = "
                Полярность выхода.
            ";
            } polarity      = 0;
            field {sw=w; hw=rw; encode=output_src_t;
            desc = "
                Источник выхода.
                FORCE_CLEAR = 0 - на выход подается значение логического нуля. При положительной полярности - \"0\", при ортицательной - \"1\".
                FORCE_SET = 1 - на выход подается значение логической единицы. При положительной полярности - \"1\", при ортицательной - \"0\".
                GENERATOR = 2 - на выход подается значение выхода генератора.
            ";
            } out_src[2] = output_src_t::FORCE_CLEAR;
            field {sw=w; hw=rw; encode=trig_src_t;
            desc = "
                Источник триггера генератора одиночных импульсов.
                EVENT = 0 - trigger от таблицы маппинга.
                PERIOD = 1 - переодический счетчик.
            ";
            } trig_src[1]  = trig_src_t::EVENT;
        } gen_cr_c;

        reg {
            name = "DELAY_LSB";
            desc = "
                Значение компаратора задержки генерации. Младшее слово.
            ";
            field {sw=rw; hw=r;} delay_lsb[32] = 0;
        } delay_lsb;
        reg {
            name = "DELAY_MSB";
            desc = "
                Значение компаратора задержки генерации. Старшее слово.
            ";
            field {sw=rw; hw=r;} delay_msb[32] = 0;
        } delay_msb;

        reg {
            name = "WIDTH_LSB";
            desc = "
                Значение компаратора ширины импульса. Младшее слово.
            ";
            field {sw=rw; hw=r;} width_lsb[32] = 0;
        } width_lsb;
        reg {
            name = "WIDTH_MSB";
            desc = "
                Значение компаратора ширины импульса. Старшее слово.
            ";
            field {sw=rw; hw=r;} width_msb[32] = 0;
        } width_msb;

        reg {
            name = "PERIOD_LSB";
            desc = "
                Значение компаратора периода генерации. Младшее слово.
            ";
            field {sw=rw; hw=r;} period_lsb[32] = 0;
        } period_lsb;
        reg {
            name = "PERIOD_MSB";
            desc = "
                Значение компаратора периода генерации. Младшее слово.
            ";
            field {sw=rw; hw=r;} period_msb[32] = 0;
        } period_msb;
    } gen_regs [`SIGNAL_GEN_N];
};