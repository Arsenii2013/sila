addrmap ev_seq_axi_core{
    name = "Модуль генерации последовательности";
    desc = "
        Модуль генерации последовательности представляет собой память, хранящую 128 битные
        записи формата \"mem entry example\", со схемой извечения записей из памяти и 
        генерации событий по внутреннему счетчику. Управляющие регистры вынесены в модуль управления 
        последовательностями. Генерация последовательности начинается по положительному фронту
        триггера. Модуль запрашивает первую запись из памяти и выставляет running. На следующем 
        такте модуль запрашивает вторую запись, а значение счетчика первой записи сравнивает 
        с текущим значением. На следующий такт, если значения равны, то генерируется событие из 
        первой записи, из памяти запрашивается третья запись, и сравнивается счетчик из второй 
        записи. И так до конца последовательности. Концом последовательности считается событие 
        0x50dead. В зависимости от значения mode в конце последовательности: SINGLE - генерация
        останавливается, указатель чтения из памяти сбрасывается, running сбрасывается, enable 
        сбрасывается, CYCLE - генератор ждет триггера, указатель чтения из памяти сбрасывается,
        running сбрасывается, enable остается, RECYCLE - генератор перезапускается, указатель 
        чтения из памяти сбрасывается, running остается, enable остается.
    ";

    /*reg {
        name = "mem entry example";
        regwidth = 128;
        field {sw=rw; hw=na;} cycle_cnt_lsb [32] = 0;
        field {sw=rw; hw=na;} cycle_cnt_msb [32] = 0;
        field {sw=rw; hw=na;} ev            [24] = 0;
        field {sw=rw; hw=na;} reserved      [40] = 0;
    } mem_entry_example;*/

    external mem {
        mementries = 4096;
        memwidth = 32;
    } seq_mem;
};