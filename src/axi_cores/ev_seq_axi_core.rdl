addrmap ev_seq_axi_core{
    name = "Модуль генератора последовательности";
    desc = "
        Генератор последовательности это 64-битный счетчик и таблица, хранящая 128 битные 
        записи формата: значение счетчика (таймстемп) - событие которое надо сгенерировать, с 
        логикой извлечения записей из нее (указателя чтения). В начале генерации счетчик и указатель 
        чтения равны нулю, извлекается первая запись из таблицы. На каждый такт проверяется, 
        равен ли таймстемп таймстемпу события из записи, извлеченной из таблицы, и инкрементируется 
        таймстемп. Если таймстемпы равны, то адрес инкрементируется и извлекается следующая запись, 
        и т. д. Концом последовательности считается событие 0x50dead. Условия запуска генерации и 
        действия после окончания генерации задаются в модуле управления генераторами последовательностей.
        Генератор последовательности отдает в модуль управления только один флаг running, показывающий
        идет ли сейчас процесс генерации последовательности. 
        
        Для правильной работы генератора записи в таблице должны идти в порядке возрастания таймстемпа,
        значение таймстемпа меньше чем в предыдущей записи означает переполнение счетчика между ними. 
        То есть счетчик должен досчитать до 2^64, переполнится, и начать считать с нуля, что приведет 
        к задержке между событиями порядка 10^11 секунд. 
        Изменять таблицу можно только когда генерация остановлена (running = 0). Запись во время работы может привести 
        к тому что текущий таймстемп будет больше того, на который указывает указатель чтения, и событие
        сгенерируется только после переполнения счетчика.
    ";

    /*reg {
        name = "Фармат записей в таблице";
        regwidth = 128;
        field {sw=rw; hw=na;} cycle_cnt_lsb [32] = 0;
        field {sw=rw; hw=na;} cycle_cnt_msb [32] = 0;
        field {sw=rw; hw=na;} ev            [24] = 0;
        field {sw=rw; hw=na;} reserved      [40] = 0;
    } mem_entry_example;*/

    external mem {
        mementries = 4096;
        memwidth = 32;
    } seq_mem;
};