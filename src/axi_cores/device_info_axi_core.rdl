addrmap device_info_axi_core{
    name = "Блок общей информации";
    desc = "
        Блок предоставляющий общую информацию об устройстве: тип, аппаратную версию, версию прошивки, серийный номер
    ";
    enum device_type_encoding {
        EVG = 32'h1;
        EVR = 32'h2;
    };

    reg {
        name = "SR";
        desc = "
        ";
        field {sw=r; hw=w;} reserved[32] = 0;
    } sr;

    reg {
        name = "CR";
        desc = "
        ";
        field {sw=rw; hw=rw;} reserved[32] = 0;
    } cr;

    reg {
        name = "CR_S";
        desc = "
        ";
        field {sw=w; hw=rw; onwrite=woset;} reserved[32] = 0;
    } cr_s;

    reg {
        name = "CR_C";
        desc = "
        ";
        field {sw=w; hw=rw;  onwrite=woclr;} reserved[32] = 0;
    } cr_c;

    reg {
        name = "DEVICE_TYPE";
        desc = "
            Идентификатор типа устройства
        ";
        field {sw=r; hw=w; encode = device_type_encoding; } device_type[32] = device_type_encoding::EVG;
    } device_type;

    reg {
        name = "HW_VERSION";
        desc = "
            Аппаратная версия
        ";
        field {sw=rw; hw=na; } hw_version[32] = 0x00010001;
    } hw_version;

    reg {
        name = "FW_VERSION";
        desc = "
            Версия прошивки старшее слово
        ";
        field {sw=r; hw=w; } hw_version[32] = 0x00010003;
    } fw_version;

    reg {
        name = "FW_HASH";
        desc = "
            Версия прошивки младшее слово (hash коммита)
        ";
        field {sw=r; hw=w; } fw_hash[32] = 32'h8d7045c8;
    } fw_hash;

    reg {
        name = "SERIAL";
        desc = "
            Серийный номер
        ";
        field {sw=rw; hw=na; } serial[32] = 10;
    } serial;
};