addrmap device_info_axi_core{
    name = "Модуль общей информации";
    desc = "
        Модуль предоставляющий общую информацию об устройстве: тип, аппаратную версию, версию прошивки, серийный номер
    ";
    enum device_type_encoding {
        SIM     = 32'h0;
        EVG     = 32'h1;
        EVR     = 32'h2;
        FANOUT  = 32'h3;
    };

    reg {
        name = "SR";
        desc = "
            Регистр статуса модуля, в настоящее время не реализован.
        ";
        field {sw=r; hw=w;} reserved[32] = 0;
    } sr;

    reg {
        name = "CR";
        desc = "
            Регистр управления модулем, в настоящее время не реализован.
        ";
        field {sw=rw; hw=rw;} reserved[32] = 0;
    } cr;

    reg {
        name = "CR_S";
        desc = "
            Регистр установки бит (SET) в регистре управления модулем, в настоящее время не реализован. 
            При чтении возвращает 0.
            При записи, в регистр cr устанавливается значение cr | cr_s (ИЛИ), то есть выставляются в 1 все биты, выставленные в 1 регистре cr_s.
        ";
        field {sw=w; hw=rw;} reserved[32] = 0;
    } cr_s;

    reg {
        name = "CR_C";
        desc = "
            Регистр сброса бит (CLEAR) в регистре управления модулем, в настоящее время не реализован.
            При чтении возвращает 0.
            При записи, в регистр cr устанавливается значение cr & ~cr_c, то есть выставляются в 0 все биты, выставленные в 1 регистре cr_s.
        ";
        field {sw=w; hw=rw;} reserved[32] = 0;
    } cr_c;

    reg {
        name = "DEVICE_TYPE";
        desc = "
            Идентификатор типа устройства.
        ";
        field {sw=r; hw=w; encode = device_type_encoding; } device_type[32] = device_type_encoding::EVG;
    } device_type;

    reg {
        name = "HW_VERSION";
        desc = "
            Аппаратная версия.
        ";
        field {sw=rw; hw=na; } hw_version[32] = 0;
    } hw_version;

    reg {
        name = "FW_VERSION";
        desc = "
            Версия прошивки старшее слово.
        ";
        field {sw=r; hw=w; } minor[16] = 0;
        field {sw=r; hw=w; } major[16] = 0;
    } fw_version;

    reg {
        name = "FW_HASH";
        desc = "
            Версия прошивки младшее слово (hash коммита).
        ";
        field {sw=r; hw=w; } fw_hash[32] = 0;
    } fw_hash;

    reg {
        name = "SERIAL";
        desc = "
            Серийный номер. В настоящее время не реализован.
        ";
        field {sw=rw; hw=na; } serial_number[32] = 0;
    } serial_number;
};