addrmap gen_map_axi_core{
    name = "Таблица маппинга генераторов";
    desc = "
        Позволяет отмаппить выход каждого из генераторов сигналов на входы o1 и o2 выходных структур. 
        Номер генератора соответствует номеру записи в таблице, в записи зается, на какие входы (o1 или o2)
        каких выходных структур подается значение генератора. Биты идут по порядку, то есть сперва 2 бита коммутации
        для нулевой выходной структуры, потому 2 бита для первой, и так далее.
        На входах выходных структур сигналы со всех генераторов объединяются по ИЛИ.
    ";
    `define SIGNAL_GEN_N 16
    `define DIFF_IO_N    16
    <% $DIFF_IO_N_PERL = 16; %>

    /*reg {
        name = "Формат записей в таблице";
        regwidth = 32;
        <% for( $i = 0; $i < $SIGNAL_GEN_N_PERL; $i += 1 ) { %>
        field {sw=rw; hw=r;
        desc = "
            Бит кооммутации o1.
        ";
        }   o1_ena_<%=$i%> = 0;
        field {sw=rw; hw=r;
        desc = "
            Бит кооммутации o2.
        ";
        }   o2_ena_<%=$i%> = 0;
        <% } %>
    } mem_entry;*/

    external mem {
        mementries = `SIGNAL_GEN_N * `DIFF_IO_N * 2 / 32;
        memwidth = 32;
    } map_mem;
};