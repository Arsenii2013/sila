addrmap diff_io_axi_core{
    name = "Модуль выходов";
    desc = "
    ";

    `define DIFF_IO_N 16

    enum polarity_t {
        POSITIVE = 0;
        NEGATIVE;
    };

    enum mode_t {
        TRI = 0;
        FORCE_CLEAR;
        FORCE_SET;
        GENERATOR;
        GATE;
        FLIP_FLOP;
        CLK;
    };

    addressing = compact;
    reg {
        name = "SR";
        desc = "
            Регистр статуса модуля.
        ";
        field {sw=r; hw=w;
        desc = "
            Значение на соответствующем выходе.
        ";
        }   value[`DIFF_IO_N] = 0;
    } sr;

    reg {
        name = "CR";
        desc = "
            Регистр управления модулем, в настоящее время не реализован.
        ";
        field {sw=rw; hw=rw;} reserved[32] = 0;
    } cr;

    reg {
        name = "CR_S";
        desc = "
            Регистр управления модулем, в настоящее время не реализован.
            При чтении возвращает 0.
            При записи, в регистр cr устанавливается значение cr ИЛИ cr_s, то есть выставляются в 1 все биты, выставленные в 1 регистре cr_s.
        ";
        field {sw=rw; hw=rw;} reserved[32] = 0;
    } cr_s;

    reg {
        name = "CR_C";
        desc = "
            Регистр управления модулем, в настоящее время не реализован.
            При чтении возвращает 0.
            При записи, в регистр cr устанавливается значение cr И НЕ cr_c, то есть выставляются в 0 все биты, выставленные в 1 регистре cr_c.
        ";
        field {sw=rw; hw=rw;} reserved[32] = 0;
    } cr_c;

    regfile {
        name = "OUT_REGS";
        desc = "
            Регистры выхода.
        ";
        reg {
            name = "OUT_SR";
            desc = "
                Регистр состояния выхода.
            ";
            field {sw=r; hw=w;}   value     = 0;
        } out_sr;

        reg {
            name = "OUT_CR";
            desc = "
                Регистр управления выходом.
            ";
            field {sw=rw; hw=rw; encode=polarity_t;
            desc = "
                Полярность.
            ";
            } polarity      = 0;
            field {sw=rw; hw=rw; encode=mode_t;
            desc = "
                Режим работы.
                TRI = 0 - высокоимпедансное состояние
                FORCE_CLEAR = 1 - на выход подается значение логического нуля.
                FORCE_SET = 2 - на выход подается значение логической единицы.
                GENERATOR = 3 - на выход подается значение от генератора сигналов со входа o1.
                GATE = 4 - гейтирование, на выход подается значение o1 И o2.
                FLIP_FLOP = 5 - RS-триггер, S - o1, R - o2.
                CLK = 6 - выход тактового сигнала.
            ";
            } mode[8] = mode_t::TRI;
        } out_cr;

        reg {
            name = "OUT_CR_S";
            desc = "
                Регистр управления каналом генерации сигналов.
                При чтении возвращает 0.
                При записи, в регистр cr устанавливается значение cr ИЛИ cr_s, то есть выставляются в 1 все биты, выставленные в 1 регистре cr_s.
            ";
            field {sw=rw; hw=rw; encode=polarity_t;
            desc = "
                Полярность.
            ";
            } polarity      = 0;
            field {sw=rw; hw=rw; encode=mode_t;
            desc = "
                Режим работы.
                TRI = 0 - высокоимпедансное состояние
                FORCE_CLEAR = 1 - на выход подается значение логического нуля.
                FORCE_SET = 2 - на выход подается значение логической единицы.
                GENERATOR = 3 - на выход подается значение от генератора сигналов со входа o1.
                GATE = 4 - гейтирование, на выход подается значение o1 И o2.
                FLIP_FLOP = 5 - RS-триггер, S - o1, R - o2.
                CLK = 6 - выход тактового сигнала.
            ";
            } mode[8] = mode_t::TRI;
        } out_cr_s;

        reg {
            name = "OUT_CR_C";
            desc = "
                Регистр управления каналом генерации сигналов.
                При чтении возвращает 0.
                При записи, в регистр cr устанавливается значение cr И НЕ cr_c, то есть выставляются в 0 все биты, выставленные в 1 регистре cr_s.
            ";
            field {sw=rw; hw=rw; encode=polarity_t;
            desc = "
                Полярность.
            ";
            } polarity      = 0;
            field {sw=rw; hw=rw; encode=mode_t;
            desc = "
                Режим работы.
                TRI = 0 - высокоимпедансное состояние
                FORCE_CLEAR = 1 - на выход подается значение логического нуля.
                FORCE_SET = 2 - на выход подается значение логической единицы.
                GENERATOR = 3 - на выход подается значение от генератора сигналов со входа o1.
                GATE = 4 - гейтирование, на выход подается значение o1 И o2.
                FLIP_FLOP = 5 - RS-триггер, S - o1, R - o2.
                CLK = 6 - выход тактового сигнала.
            ";
            } mode[8] = mode_t::TRI;
        } out_cr_c;
    } out_regs [`DIFF_IO_N];
};